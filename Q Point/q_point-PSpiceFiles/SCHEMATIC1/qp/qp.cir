** Profile: "SCHEMATIC1-qp"  [ D:\University\Habib\Sem 4\Basic Electronics\Lab\Lab 11\q_point-PSpiceFiles\SCHEMATIC1\qp.sim ]

** Creating circuit file "qp.cir"
** WARNING: THIS AUTOMATICALLY GENERATED FILE MAY BE OVERWRITTEN BY SUBSEQUENT SIMULATIONS

*Libraries:
* Profile Libraries :
* Local Libraries :
* From [PSPICE NETLIST] section of C:\Users\Yousuf Lali\AppData\Roaming\SPB_Data\cdssetup\OrCAD_PSpice\17.2.0\PSpice.ini file:
.lib "nomd.lib"

*Analysis directives:
.DC LIN V_V4 0 15 0.1
+ LIN V_V5 0.6 1 0.02
.OPTIONS ADVCONV
.PROBE64 V(alias(*)) I(alias(*)) W(alias(*)) D(alias(*)) NOISE(alias(*))
.INC "..\SCHEMATIC1.net"

.END
